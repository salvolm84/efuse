* tb28_bypass_precharge.cir
* ---------------------------------------------------------------------------
* Can the low-current bypass pre-charge a capacitive load?
* Stand-by (CPON = 0, OUTCTL = 0); at 1 ms the MCU turns on only the bypass
* (BYPCTL = 1) into a discharged load: C_LOAD = 0.1 mF or 1 mF (+ 4.7k).
* Expected: the ~7 Ohm bypass current is limited to ~0.12 A, so VS - VOUT
* stays > 1.3 V: BYPASS_SAT after 5 us -> AUTO-ON: the charge pump starts
* and the hardware switches the main FET on through its slew network
* (module default C_SLEW 47 nF, ~97 V/ms). 0.1 mF then charges in ~0.5 ms
* (~10 A); 1 mF needs ~100 A and trips the HSC (as tb11). The bypass never
* pre-charges anything: the main FET always does.
* Interview guide: question D3 (follow-up).
* ---------------------------------------------------------------------------
.include ../models/VNF1048F_beh.lib
.param CL=1m

Vbat bat 0 48
Rbat bat b1 10m
Lbat b1 vbat 1u
Dtvs 0 vbat EF_TVS58V
Cbus vbat 0 100u Rser=30m

X1 vbat out 0 en byp clr diag cs tfet EFUSE48_MOD RSENSE=1m OVC_CODE=13 HSC_CODE=12
+ VDS_CODE=14 TNOM_CODE=0 CPON=0

Lh out o1 1u
Rh o1 load 10m
Cload load 0 {CL} Rser=10m
Rbl load 0 4.7k
Dfw 0 out EF_SCH100V

Ven en 0 0
Vbyp byp 0 PWL(0 0 1m 0 1.001m 3.3)
Vclr clr 0 0

.save V(vbat) V(out) V(load) V(diag) I(Lh) V(x1:cp) V(x1:g) I(x1:xu:bbyp)
.save V(x1:xu:autoon) V(x1:xu:byp) V(x1:xu:gcmd) V(x1:xu:hsht) V(x1:xu:flt)
.meas tran ibyp   max I(x1:xu:bbyp) from 1m to 1.02m
.meas tran t_auto find time when V(x1:xu:autoon)=0.5 rise=1
.meas tran dt_auto param t_auto-1m
.meas tran t_gon  find time when V(x1:xu:gcmd)=0.5 rise=1
.meas tran ipk    max I(Lh) from 1m to 4m
.meas tran t_hsc  find time when V(x1:xu:hsht)=0.5 rise=1
.meas tran vend   avg V(load) from 3.9m to 4m
.step param CL list 0.1m 1m
.tran 0 4m 0 0.5u
.options plotwinsize=0
.end
