* oc02_timer_logic.cir
* ---------------------------------------------------------------------------
* Overcurrent-switch logic: timer restart, current direction, reset by EN,
* auto-retry and the built-in fault hooks. Six OCSW (IMAX = 10 A, TOC = 1 ms),
* each fed by its own 12 V source (1 mOhm), base load 5 A:
*   X1  15 A for 0.8 ms, three times, separated by 50 us at 5 A (1.0 .. 3.5
*       ms); then 15 A from 5 ms to 7 ms; EN low from 8.0 to 8.1 ms
*   X2  DIR = 1: 20 A reverse (OUT -> IN, from a 24 V source) 1 .. 3 ms,
*       then 20 A forward from 5 ms
*   X3  DIR = 0: the same reverse current
*   X4  TRETRY = 5 ms: a 0.1 Ohm short from 1 ms to the end
*   X5  fault hook, mode 1 (stuck-on) from 0.5 ms: 20 A from 1 ms
*   X6  fault hook, mode 2 (stuck-off) from 2 ms
* Expected (model equations, README part 7):
*   X1: no trip during the interrupted overloads (the timer restarts in
*       TRST = 1 us at every dip: its maximum is 0.8 ms - the sense delay);
*       trip at 5 ms + TSNS ln((I1 - I0)/(I1 - IMAX)) + TOC; EN low clears
*       FLT and the switch closes again (5 A at 9 ms)
*   X2: no trip in reverse; trip 1 ms after the forward step
*   X3: trip 1 ms after the reverse step
*   X4: hiccup: on for TSNS ln(..) + TOC, off for TRETRY: trips at
*       ~2, 8, 14, 20, 26 ms; period TOC + TRETRY + sense delay
*   X5: FLT reports the trip at ~2 ms but the current keeps flowing
*   X6: the switch opens at 2 ms (leakage only), FLT stays low
* Max step 200 ns (trip instants resolved to one time step).
* ---------------------------------------------------------------------------
.include ../models/OCSW_beh.lib
* load resistors for 12 V (series resistance of source + RON + load switch ~3 mOhm)
.param RB=2.397 R15=1.197 R20=0.797 RREV=0.48

* --- X1: interrupted overloads, then a persistent one, then EN reset
V1 s1 0 12
R1 s1 in1 1m
X1 in1 out1 0 en1 flt1 OCSW IMAX=10 TOC=1m
Rb1 out1 0 {RB}
Ro1 out1 o1 {R15}
S1 o1 0 g1 0 SLOAD
Vg1 g1 0 PWL(0 0 1m 0 1.000001m 1 1.8m 1 1.800001m 0 1.85m 0 1.850001m 1
+ 2.65m 1 2.650001m 0 2.7m 0 2.700001m 1 3.5m 1 3.500001m 0
+ 5m 0 5.000001m 1 7m 1 7.000001m 0)
Ven1 en1 0 PWL(0 3.3 8m 3.3 8.000001m 0 8.1m 0 8.100001m 3.3)

* --- X2 (DIR = 1) and X3 (DIR = 0): reverse current from a 24 V source on OUT
V2 s2 0 12
R2 s2 in2 1m
X2 in2 out2 0 en flt2 OCSW IMAX=10 TOC=1m DIR=1
Rb2 out2 0 {RB}
Vr2 r2 0 24
Rr2 r2 q2 {RREV}
S2r q2 out2 gr 0 SLOAD
Ro2 out2 o2 {R20}
S2 o2 0 gf 0 SLOAD

V3 s3 0 12
R3 s3 in3 1m
X3 in3 out3 0 en flt3 OCSW IMAX=10 TOC=1m DIR=0
Rb3 out3 0 {RB}
Vr3 r3 0 24
Rr3 r3 q3 {RREV}
S3r q3 out3 gr 0 SLOAD
Vgr gr 0 PWL(0 0 1m 0 1.000001m 1 3m 1 3.000001m 0)
Vgf gf 0 PWL(0 0 5m 0 5.000001m 1)

* --- X4: auto-retry into a persistent short
V4 s4 0 12
R4 s4 in4 1m
X4 in4 out4 0 en flt4 OCSW IMAX=10 TOC=1m TRETRY=5m
Rb4 out4 0 {RB}
Ro4 out4 o4 0.1
S4 o4 0 gs 0 SLOAD
Vgs gs 0 PWL(0 0 1m 0 1.000001m 1)

* --- X5 / X6: fault hooks (scenario 1 selected)
V5 s5 0 12
R5 s5 in5 1m
X5 in5 out5 0 en flt5 OCSW IMAX=10 TOC=1m FI_ID=1 FID=1 FI_MODE=1 FI_T=0.5m
Rb5 out5 0 {RB}
Ro5 out5 o5 {R20}
S5 o5 0 gs 0 SLOAD

V6 s6 0 12
R6 s6 in6 1m
X6 in6 out6 0 en flt6 OCSW IMAX=10 TOC=1m FI_ID=1 FID=1 FI_MODE=2 FI_T=2m
Rb6 out6 0 {RB}

.model SLOAD SW(Ron=1m Roff=1G Vt=0.5 Vh=-0.2)
Ven en 0 3.3

.save I(x1:Vs) I(x2:Vs) I(x3:Vs) I(x4:Vs) I(x5:Vs) I(x6:Vs) V(en1)
+ V(flt1) V(flt2) V(flt3) V(flt4) V(flt5) V(flt6)
+ V(x1:tm) V(x2:tm) V(x3:tm) V(x4:tm) V(x4:tr) V(x1:isf)
* X1
.meas tran i0_1   avg I(x1:Vs) from 0.5m to 0.95m
.meas tran i1_1   find I(x1:Vs) at 1.4m
.meas tran tmax_1 max V(x1:tm) from 0.5m to 4.9m
.meas tran tf_1   find time when V(flt1)=1.65 rise=1
.meas tran fl_1   find V(flt1) at 9m
.meas tran ie_1   avg I(x1:Vs) from 9m to 10m
* X2, X3
.meas tran ir_2   find I(x2:Vs) at 2m
.meas tran ir_3   find I(x3:Vs) at 1.4m
.meas tran i0_2   avg I(x2:Vs) from 4.5m to 4.95m
.meas tran i1_2   find I(x2:Vs) at 5.4m
.meas tran tf_2   find time when V(flt2)=1.65 rise=1
.meas tran tf_3   find time when V(flt3)=1.65 rise=1
* X4
.meas tran i1_4   find I(x4:Vs) at 1.4m
.meas tran tr1_4  find time when V(flt4)=1.65 rise=1
.meas tran tr2_4  find time when V(flt4)=1.65 rise=2
.meas tran tr5_4  find time when V(flt4)=1.65 rise=5
.meas tran tl2_4  find time when V(flt4)=1.65 fall=2
.meas tran ioff_4 avg I(x4:Vs) from 3m to 6m
* X5, X6
.meas tran tf_5   find time when V(flt5)=1.65 rise=1
.meas tran i_5    avg I(x5:Vs) from 3m to 4m
.meas tran i_6    avg I(x6:Vs) from 3m to 4m
.meas tran f_6    max V(flt6) from 0 to 30m
.tran 0 30m 0 200n
.end
