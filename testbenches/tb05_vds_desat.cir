* tb05_vds_desat.cir
* ---------------------------------------------------------------------------
* External-FET desaturation (VDS) protection and the 960 us start-up blanking.
* A large capacitive load (680 uF) is switched on with two gate slew settings:
*   C_SLEW =  47 nF : OUT ramps in ~0.6 ms  -> finished inside VDS_BLK, OK
*                     (inrush ~65 A: inside the I2t window, below IHSC)
*   C_SLEW = 470 nF : OUT ramps in ~6 ms    -> at the end of the 960 us
*                     blanking VDS is still >> VDS_THR (1.0 V) -> VDS_MAX
* Design rule shown:  t_ramp = VBAT*C_SLEW/I_G  must be  < VDS_BLK (960 us)
* while the inrush C_LOAD*dV/dt must stay below IHSC (and inside the FET SOA).
* ---------------------------------------------------------------------------
.include ../models/VNF1048F_beh.lib
.param CSL=47n

Vbat bat 0 48
Rbat bat b1 10m
Lbat b1 vbat 1u
Dtvs 0 vbat EF_TVS58V
Cbus vbat 0 100u Rser=30m

X1 vbat out 0 en byp clr diag cs tfet EFUSE48_MOD RSENSE=1m OVC_CODE=13 HSC_CODE=12
+ VDS_CODE=14 TNOM_CODE=0 C_SLEW={CSL}

Lh out o1 1u
Rh o1 load 10m
Cload load 0 680u Rser=10m
Rload load 0 9.6
Dfw 0 out EF_SCH100V

Ven en 0 PWL(0 0 0.5m 0 0.501m 3.3)
Vbyp byp 0 0
Vclr clr 0 0

.save V(vbat) V(out) V(diag) V(cs) V(tfet) I(Lh) V(x1:hsg) V(x1:g) V(x1:drn)
.save V(x1:xu:vdsmax) V(x1:xu:ton) V(x1:xu:fd) V(x1:xu:gcmd) V(x1:xu:hsht)
.meas tran t_vds  find time when V(x1:xu:vdsmax)=0.5 rise=1
.meas tran dt_vds param t_vds-0.5m
.meas tran ipk   max I(Lh)
.meas tran vout_end avg V(out) from 9m to 10m
.meas tran fdmax max V(x1:xu:fd)
.meas tran tjmax max V(tfet)
.step param CSL list 47n 470n
.tran 0 10m 0 1u
.options plotwinsize=0
.end
