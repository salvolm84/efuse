* tb02_hard_short.cir
* ---------------------------------------------------------------------------
* Hard short circuit at the end of the load harness while the channel is ON.
*   t = 0.5 ms  OUTCTL on (10 A load)
*   t = 3.0 ms  short (5 mOhm) applied at the load connector
*   t = 6.0 ms  CLR pulse (MCU clears HSHT/FUSE_LATCH) -> retry into the short
*   t = 9.0 ms  short removed,  t = 10 ms  CLR -> normal restart
* Expected: current rises at ~L di/dt, HSC threshold (105.6 A) + 5 us delay,
*           FET off within a few us, HSHT and FUSE_LATCH latched, DIAG low,
*           battery-side inductive kick clamped by the TVS, OUT clamped by the
*           freewheel Schottky, FET VDS stays below 100 V. Retry trips again.
* ---------------------------------------------------------------------------
.include ../models/VNF1048F_beh.lib

Vbat bat 0 48
Rbat bat b1 10m
Lbat b1 vbat 1u
Dtvs 0 vbat EF_TVS58V
Cbus vbat 0 100u Rser=30m

X1 vbat out 0 en byp clr diag cs tfet EFUSE48_MOD RSENSE=1m OVC_CODE=13 HSC_CODE=12
+ VDS_CODE=14 TNOM_CODE=0

Lh out o1 1u
Rh o1 load 10m
Cload load 0 220u Rser=20m
Rload load 0 4.8
Dfw 0 out EF_SCH100V

* short circuit switch (Ron 5 mOhm) at the load connector
Ssc load 0 sc 0 SSHORT
Vsc sc 0 PWL(0 0 3m 0 3.0001m 1 9m 1 9.0001m 0)
.model SSHORT SW(Ron=5m Roff=1Meg Vt=0.5 Vh=-0.2)

Ven en 0 PWL(0 0 0.5m 0 0.501m 3.3)
Vbyp byp 0 0
Vclr clr 0 PWL(0 0 6m 0 6.001m 3.3 6.05m 3.3 6.051m 0 10m 0 10.001m 3.3 10.05m 3.3 10.051m 0)

.save V(vbat) V(out) V(load) V(diag) V(cs) V(tfet) I(Lh) I(Lbat) I(Dtvs) I(Dfw)
.save V(x1:hsg) V(x1:g) V(x1:cp) V(x1:drn)
.save V(x1:xu:hsht) V(x1:xu:fusel) V(x1:xu:gcmd) V(x1:xu:vsf) V(x1:xu:fd)

.meas tran t_trip  find time when V(x1:xu:hsht)=0.5 rise=1
.meas tran dt_trip param t_trip-3m
.meas tran ipk1    max I(Lbat) from 3m to 3.1m
.meas tran vbatpk  max V(vbat) from 3m to 3.2m
.meas tran voutmin min V(out)  from 3m to 3.2m
.meas tran vdspk   max V(x1:drn,out) from 3m to 3.2m
.meas tran vgsmax  max V(x1:g,out) from 3m to 3.2m
.meas tran t_trip2 find time when V(x1:xu:hsht)=0.5 rise=2
.meas tran ipk2    max I(Lbat) from 6m to 6.2m
.meas tran vout_end avg V(out) from 11.5m to 12m
.meas tran diag_end avg V(diag) from 11.5m to 12m

.tran 0 12m 0 0.2u
.options plotwinsize=0
.end
