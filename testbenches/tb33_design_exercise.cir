* tb33_design_exercise.cir
* ---------------------------------------------------------------------------
* The interview design exercise (guide section I), simulated.
* 48 V, 1 kW DC/DC (12 V out) with 2.2 mF +20 % = 2.64 mF input capacitance,
* UVLO 30 V on / 26 V off, fed by 3 m of 2.5 mm2 (23 mOhm, 2.5 uH).
* Channel: RSENSE 1 mOhm, OVC_CODE 19 (INOM 32.2 A), HSC_CODE 12 (IHSC
* 105.6 A), VDS_CODE 14 (1.0 V, 960 us blanking), TNOM_CODE 2 (tNOM 5 s).
*   CASE 0 : dV/dt only, C_SLEW 68 nF (~65 V/ms: fast enough for the
*            blanking) -> C*dV/dt ~ 170 A > IHSC: HSC trip
*   CASE 1 : dV/dt only, C_SLEW 220 nF (~21 V/ms, ~55 A < IHSC) -> the ramp
*            outlasts the 960 us blanking: VDS trip
*   CASE 2 : resistor pre-charge (10 Ohm, tau 26 ms) with voltage-based
*            hand-over at 95 % VBAT and the DC/DC enable gated by
*            power-good + 5 ms -> clean start
*   CASE 3 : CASE 2, then a 5 mOhm short at the DC/DC input (end of the
*            3 m feed) at 110 ms -> HSC trip with the feed inductance
* Expected: there is no dV/dt setting that works for 2.64 mF with this
* controller; the pre-charge does (95 % after ~3 tau = 79 ms; from the
* ~6 V pre-bias 1/2 C dV^2 ~ 2.3 J in the resistor, ~176 W peak).
* Interview guide: section I.
* ---------------------------------------------------------------------------
.include ../models/VNF1048F_beh.lib
.param CASE=2
.param CSL={if(CASE==1, 220n, 68n)}
.param PRE={if(CASE>=2, 1, 0)}
.param CIN=2.64m RPRE=10

Vbat bat 0 48
Rbat bat b1 20m
Lbat b1 vbat 1u
Dtvs 0 vbat EF_TVS58V
Cbus vbat 0 100u Rser=30m

X1 vbat out 0 en byp clr diag cs tfet EFUSE48_MOD RSENSE=1m OVC_CODE=19 HSC_CODE=12
+ VDS_CODE=14 TNOM_CODE=2 C_SLEW={CSL}

* 3 m of 2.5 mm2 feed
Lh out o1 2.5u
Rh o1 load 23m
Dfw 0 out EF_SCH100V
* DC/DC input: capacitance, bleeder, 1 kW constant power with UVLO
Cin load 0 {CIN} Rser=10m
Rbl load 0 4.7k
Bdcdc load 0 I=if(V(dcen)>0.5, 1000/max(V(load),20), 0)
Bdcen dcen_i 0 V=(V(dccmd)>0.5) & (V(load)>30 | (V(load)>26 & V(dcen)>0.5))
Rdcen dcen_i dcen 1k
Cdcen dcen 0 1n
Bdccmd dccmd 0 V=if({PRE}, V(pgd5), 1)

* pre-charge path: switch + 10 Ohm from VBAT to OUT (CASE 2, 3)
Spre vbat pc pact 0 SPRE
.model SPRE SW(Ron=50m Roff=10Meg Vt=0.5 Vh=-0.2)
Rpre pc out {RPRE}
* supervisor: RC-filtered comparators (20 us), hand-over at 95 %
Rfb vbat vbf 2k
Cfb vbf 0 10n
Rfl load vlf 2k
Cfl vlf 0 10n
Bpact pact 0 V={PRE} & (time>1m) & !(V(pgd)>0.5)
Bpgs pgs 0 V=(V(pact)>0.5) & (V(vlf)>0.95*V(vbf))
Xpg pgs 0 pg 0 EF_LATCH
Xpgd pg pgd 0 EF_DGL T=2m
Xpg5 pg pgd5 0 EF_DGL T=5m
Ben en 0 V=3.3*if({PRE}, V(pg), time>1m)
Vbyp byp 0 0
Vclr clr 0 0

* CASE 3: short at the DC/DC input at 110 ms
Ssc load 0 sc 0 SSHORT
Vsc sc 0 PWL(0 0 110m 0 110.0001m {if(CASE==3, 1, 0)})
.model SSHORT SW(Ron=5m Roff=1Meg Vt=0.5 Vh=-0.2)

.save V(vbat) V(out) V(load) V(pc) V(dcen) V(pg) V(pact) I(Lh) I(Rpre) V(x1:drn) V(tfet)
.save V(x1:xu:hsht) V(x1:xu:vdsmax) V(x1:xu:flt) V(x1:xu:fd) V(x1:xu:gcmd)
.meas tran ipk    max V(vbat,x1:drn)/1m from 1m to 105m
.meas tran t_hsc  find time when V(x1:xu:hsht)=0.5 rise=1
.meas tran t_vds  find time when V(x1:xu:vdsmax)=0.5 rise=1
.meas tran t_pg   find time when V(pg)=0.5 rise=1
.meas tran e_pre  integ V(pc,out)*I(Rpre)
.meas tran p_pre  max V(pc,out)*I(Rpre) from 1.1m to 105m
.meas tran idc    avg I(Lh) from 100m to 105m
.meas tran vdc    avg V(load) from 100m to 105m
.meas tran fdmax  max V(x1:xu:fd) from 0 to 105m
.meas tran isc    max V(vbat,x1:drn)/1m from 110m to 111m
.meas tran t_sc   find time when V(x1:xu:hsht)=0.5 rise=1 td=110m
.meas tran dt_sc  param t_sc-110m
.meas tran vbatpk max V(vbat) from 110m to 111m
.step param CASE list 0 1 2 3
.tran 0 112m 0 2u
.options plotwinsize=0
.end
