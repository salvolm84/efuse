* tb03_i2t_curve.cir
* ---------------------------------------------------------------------------
* Characterizes the current-vs-time latch-off (eFuse I2t curve).
* Widest setting: OVC_CODE=0 (6 mV) and HSC_CODE=15 (160 mV) -> 15 steps,
* RSENSE = 1 mOhm  ->  INOM = 6 A, IHSC = 160 A,  tNOM = 1 s (TNOM_CODE=0).
* A constant-current overload ILOAD is applied at t = 5 ms; the trip time is
* measured from FUSE_LATCH. Stepped over ILOAD and FUSE_MODE:
*   FUSE_MODE = 0 : ST stepwise curve  t = tNOM/2^m, m=floor(log2(32(x^2-1)))
*   FUSE_MODE = 1 : ideal curve        t = (tNOM/32)/(x^2-1),  x = I/INOM
* This reproduces DS13084 Figure 4 (VOC_thrs min - VHSC_thrs max).
* Post-processing: tools/plot_results.py tb03  ->  docs/img/tb03_i2t_curve.png
* ---------------------------------------------------------------------------
.include ../models/VNF1048F_beh.lib
.param ILOAD=12 MODE=0

Vbat bat 0 48
Rbat bat vbat 10m
Cbus vbat 0 100u Rser=30m

X1 vbat out 0 en byp clr diag cs tfet EFUSE48_MOD RSENSE=1m OVC_CODE=0 HSC_CODE=15
+ VDS_CODE=30 TNOM_CODE=0 FUSE_MODE={MODE} RTHCA=2

* ideal overload: constant current (resistive below 5 V so OUT=0 is defined)
Bload out 0 I={ILOAD}*u(time-5m)*limit(V(out)/5,0,1)
Rmin out 0 100k
Dfw 0 out EF_SCH100V

Ven en 0 PWL(0 0 0.5m 0 0.501m 3.3)
Vbyp byp 0 0
Vclr clr 0 0

.save V(x1:xu:xa_i) V(out) V(x1:xu:fd) V(x1:xu:fusel) V(x1:xu:hsht) V(x1:xu:xa)
.meas tran t_fl  find time when V(x1:xu:fusel)=0.5 rise=1
.meas tran ttrip param t_fl-5m
.meas tran ihsc  max V(x1:xu:hsht)
.meas tran xavg  avg V(x1:xu:xa_i) from 5.01m to 5.04m

.step param MODE list 0 1
.step param ILOAD list 6.06 6.12 6.25 6.45 6.75 7.2 8.1 9.6 12 15 19.2 25.2 33 45 60 78 102 126 150
.tran 0 1.1 0 20u
.options plotwinsize=0
.end
