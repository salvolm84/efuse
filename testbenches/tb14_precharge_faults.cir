* tb14_precharge_faults.cir
* ---------------------------------------------------------------------------
* Supervised resistor pre-charge (4.7 Ohm, 4.7 mF, tau = 22 ms) in front of a
* 1 kW 48->12 V DC/DC (constant power, UVLO 30/26 V), with the checks a
* robust pre-charge sequence needs:
*   - hand-over   : eFuse on when V(load) > 95 % VBAT (comparator, not timer)
*   - checkpoint  : at T0 + TCHK (1 tau) V(load) must be > 40 % VBAT,
*                   otherwise abort (fail fast on a short)
*   - timeout     : no hand-over by T0 + TTO (100 ms ~ 4.5 tau) -> abort
*   - DC/DC enable: 5 ms after the hand-over ("power good")
* Stepped fault cases:
*   CASE 0  normal                -> hand-over at ~66 ms, DC/DC starts
*   CASE 1  hard short at the load (50 mOhm) -> abort at the checkpoint;
*           the eFuse never closes into the short
*   CASE 2  leaky load (10 Ohm)   -> V(load) settles at ~33 V < 95 %:
*           passes the checkpoint, aborted by the timeout
*   CASE 3  DC/DC NOT gated by power-good (own UVLO only): it starts at 30 V,
*           the 4.7 Ohm path cannot carry 1 kW -> start/stop hiccup -> timeout
* ---------------------------------------------------------------------------
.include ../models/VNF1048F_beh.lib
.param CASE=0 RPRE=4.7 CL=4.7m T0=1m TCHK={RPRE*CL} TTO=100m

Vbat bat 0 48
Rbat bat b1 10m
Lbat b1 vbat 1u
Dtvs 0 vbat EF_TVS58V
Cbus vbat 0 100u Rser=30m

X1 vbat out 0 en byp clr diag cs tfet EFUSE48_MOD RSENSE=1m OVC_CODE=13 HSC_CODE=12
+ VDS_CODE=14 TNOM_CODE=0

* pre-charge path
Spre vbat pc pact 0 SPRE
.model SPRE SW(Ron=50m Roff=10Meg Vt=0.5 Vh=-0.2)
Rpre pc out {RPRE}

* load: 4.7 mF input capacitance, bleeder, DC/DC, fault elements
Lh out o1 1u
Rh o1 load 10m
Cload load 0 {CL} Rser=10m
Rbl load 0 4.7k
Dfw 0 out EF_SCH100V
Rshort load 0 {if(CASE==1, 50m, 1G)}
Rleak  load 0 {if(CASE==2, 10, 1G)}
Bdcdc load 0 I=if(V(dcen)>0.5, 1000/max(V(load),20), 0)
Bdcen dcen_i 0 V=(V(dccmd)>0.5) & (V(load)>30 | (V(load)>26 & V(dcen)>0.5))
Rdcen dcen_i dcen 1k
Cdcen dcen 0 1n
Bdccmd dccmd 0 V=if({CASE}==3, 1, V(pgd5))

* ---- pre-charge supervisor (MCU), comparator inputs RC-filtered (20 us)
Rfb vbat vbf 2k
Cfb vbf 0 10n
Rfl load vlf 2k
Cfl vlf 0 10n
Bpact pact 0 V=(time>{T0}) & !(V(abort)>0.5) & !(V(pgd)>0.5)
Bpgs pgs 0 V=(V(pact)>0.5) & (V(vlf)>0.95*V(vbf))
Xpg pgs 0 pg 0 EF_LATCH
Xpgd pg pgd 0 EF_DGL T=2m
Xpg5 pg pgd5 0 EF_DGL T=5m
Babs abs 0 V=(time>{T0}) & !(V(pg)>0.5) & ( ((time>{T0+TCHK}) & (V(vlf)<0.4*V(vbf)))
+  | (time>{T0+TTO}) )
Xab abs 0 abort 0 EF_LATCH
Ben en 0 V=3.3*V(pg)
Vbyp byp 0 0
Vclr clr 0 0

.save V(vbat) V(out) V(load) V(pc) V(pact) V(pg) V(abort) V(dcen) I(Rpre) I(Lh)
.save V(x1:drn) V(x1:xu:gcmd) V(x1:xu:hsht) V(x1:xu:flt) V(x1:xu:fd) V(diag)
.meas tran t_pg   find time when V(pg)=0.5 rise=1
.meas tran t_ab   find time when V(abort)=0.5 rise=1
.meas tran dt_ab  param t_ab-T0
.meas tran v_chk  find V(load) at {T0+TCHK}
.meas tran v_ab   find V(load) when V(abort)=0.5 rise=1
.meas tran e_pre  integ V(pc,out)*I(Rpre)
.meas tran ipre   max I(Rpre)
.meas tran ifet   max V(vbat,x1:drn)*1k*V(x1:xu:gcmd)
.meas tran fltmax max V(x1:xu:flt)
.meas tran gcmax  max V(x1:xu:gcmd)
.meas tran t_dc1  find time when V(dcen)=0.5 rise=1
.meas tran t_dc3  find time when V(dcen)=0.5 rise=3
.meas tran idc    avg I(Lh) from 115m to 120m
.meas tran vend   avg V(load) from 115m to 120m
.step param CASE list 0 1 2 3
.tran 0 120m 0 5u
.options plotwinsize=0
.end
