* tb23_linear_soa.cir
* ---------------------------------------------------------------------------
* Linear-mode stress of the FET during a dV/dt start-up, at hot ambient.
* Module with C_SLEW 68 nF (~65 V/ms, inside the tb11 window), TAMB 85 degC,
* C_LOAD stepped 0.22 / 0.47 / 1 mF (+ 4.7k bleeder).
* Expected: the FET runs as a source follower: P = VDS * C*dV/dt, a
* triangle from ~VBAT*I down to 0 over ~0.6 ms, energy ~1/2*C*(VBAT-V0)^2
* (V0 = 6 V pre-bias: 0.19 / 0.41 / 0.88 J) whatever the ramp. The junction (CTHJ 20 mJ/K) rises
* by tens of K within the pulse while the drain pad, where the NTC sits,
* barely moves: the NTC cannot protect against a linear-mode pulse; the
* datasheet SOA curve at ~1 ms, derated to hot Tj, has to.
* Interview guide: questions C1, E1.
* ---------------------------------------------------------------------------
.include ../models/VNF1048F_beh.lib
.param CL=1m

Vbat bat 0 48
Rbat bat b1 10m
Lbat b1 vbat 1u
Dtvs 0 vbat TVS_58V
Cbus vbat 0 100u Rser=30m

X1 vbat out 0 en byp clr diag cs tfet EFUSE48_MOD RSENSE=1m OVC_CODE=13 HSC_CODE=12
+ VDS_CODE=14 TNOM_CODE=0 C_SLEW=68n TAMB=85

Lh out o1 1u
Rh o1 load 10m
Cload load 0 {CL} Rser=10m
Rbl load 0 4.7k
Dfw 0 out SCH_100V

Ven en 0 PWL(0 0 0.5m 0 0.501m 3.3)
Vbyp byp 0 0
Vclr clr 0 0

.save V(vbat) V(out) V(x1:drn) I(Lh) V(tfet) V(x1:tcf) V(x1:xu:flt)
.meas tran v0    avg V(out) from 0.4m to 0.5m
.meas tran ipk   max I(Lh) from 0.5m to 3m
.meas tran ppk   max V(x1:drn,out)*V(vbat,x1:drn)/1m from 0.5m to 3m
.meas tran e_fet integ V(x1:drn,out)*V(vbat,x1:drn)/1m from 0.5m to 3m
.meas tran t20   find time when V(out)=0.2*48 rise=1
.meas tran t90   find time when V(out)=0.9*48 rise=1
.meas tran tjpk  max V(tfet)
.meas tran tcpk  max V(x1:tcf)
.meas tran fltmax max V(x1:xu:flt)
.step param CL list 0.22m 0.47m 1m
.tran 0 3m 0 0.5u
.options plotwinsize=0
.end
