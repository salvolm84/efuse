* tb34_cold_start.cir
* ---------------------------------------------------------------------------
* Debug scenario J1: "the channel to the DC/DC trips at key-on, only cold".
* Discrete VNF1048F channel, dV/dt start-up (RG_ON 2.2k, C_SLEW 82 nF) into
* a 1 kW DC/DC (UVLO 30/26 V, NOT gated: it starts on its own UVLO during
* the ramp). Three parameter sets (illustrative values, not a datasheet):
*   CASE 0 : 25 degC typical: FET VGS(th) 3.2 V, gate drive VGS_ON 14 V,
*            C_IN 1 mF / 10 mOhm ESR, battery 10 mOhm
*   CASE 1 : -40 degC: VGS(th) +0.4 V (about -6 mV/K), electrolytic C -20 %,
*            ESR x5, battery internal resistance x4
*   CASE 2 : CASE 1 with the gate drive at the low end of its specified
*            range (VGS_ON 12 V instead of 14 V; slower charge pump / driver)
* Expected: at 25 degC OUT reaches 95 % ~0.8 ms after OUTCTL, ~17 % inside
* the 960 us VDS blanking. The source-follower ramp rate is set by the gate
* current (VGS_ON - VGS_plateau)/RG_ON: the cold threshold alone costs ~6 %
* (CASE 1 still passes); with the weaker gate drive as well, OUT is still
* volts below VBAT when the blanking ends -> VDS_MAX latch (CASE 2).
* It is the VDS monitor, not the HSC or the I2t, that fires: read the
* latched fault before guessing.
* Interview guide: question J1.
* ---------------------------------------------------------------------------
.include ../models/VNF1048F_beh.lib
.param CASE=0
.param VTO={if(CASE>=1, 3.6, 3.2)}
.param CIN={if(CASE>=1, 0.8m, 1m)}
.param ESR={if(CASE>=1, 50m, 10m)}
.param RBAT={if(CASE>=1, 40m, 10m)}
.param VGSON={if(CASE==2, 12, 14)}
.model FETJ VDMOS(Rg=1.2 Vto={VTO} Rd=0.9m Rs=0.4m Rb=1.5m Kp=180 lambda=0.01
+  Cgdmax=3.5n Cgdmin=80p a=0.6 Cgs=9n Cjo=3n m=0.55 Is=5p N=1.05 BV=100 Ibv=10u tt=50n)

Vbat bat 0 48
Rbat bat b1 {RBAT}
Lbat b1 vbat 1u
Dtvs 0 vbat EF_TVS58V
Cbus vbat 0 100u Rser=30m

* ---- discrete channel
Rsh vbat drn 1m
XU vbat cp vbat drn hsg out ntc ntcm 0 diag en 0 0 cs VNF1048F OVC_CODE=19 HSC_CODE=12
+ VDS_CODE=14 NTC_CODE=4 TNOM_CODE=2 VGS_ON={VGSON}
Cvs vbat 0 100n
Ccp cp vbat 470n
Rgon hsg g 2.2k
Rgoff hsg goff 10
Dgoff g goff EF_DSW
Cslw g 0 82n
Dzgs out g EF_DZ15
Rgb g out 47k
M1 drn g out out FETJ
Rntc drn ntc 10k
Rtref ntc ntcm 10k
Vlog v33 0 3.3
Rpu v33 diag 4.7k

* ---- DC/DC load, starts on its own UVLO
Lh out o1 1u
Rh o1 load 10m
Dfw 0 out EF_SCH100V
Cin load 0 {CIN} Rser={ESR}
Rbl load 0 4.7k
Bdcdc load 0 I=if(V(dcen)>0.5, 1000/max(V(load),20), 0)
Bdcen dcen_i 0 V=(V(load)>30 | (V(load)>26 & V(dcen)>0.5))
Rdcen dcen_i dcen 1k
Cdcen dcen 0 1n

Ven en 0 PWL(0 0 0.5m 0 0.501m 3.3)

.save V(vbat) V(out) V(load) V(g) V(drn) I(Lh) V(dcen) V(diag)
.save V(xu:hsht) V(xu:vdsmax) V(xu:fusel) V(xu:flt) V(xu:fd) V(xu:gcmd)
.meas tran ipk    max I(Lh) from 0.5m to 3m
.meas tran t_dc   find time when V(dcen)=0.5 rise=1
.meas tran t95    find time when V(out)=45.6 rise=1
.meas tran vds_b  find V(drn,out) at 1.46m
.meas tran vbat_b find V(vbat) at 1.46m
.meas tran t_vds  find time when V(xu:vdsmax)=0.5 rise=1
.meas tran t_hsc  find time when V(xu:hsht)=0.5 rise=1
.meas tran fdmax  max V(xu:fd)
.meas tran vend   avg V(load) from 2.9m to 3m
.step param CASE list 0 1 2
.tran 0 3m 0 0.5u
.options plotwinsize=0
.end
