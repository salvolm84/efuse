* tb26_hard_turn_on.cir
* ---------------------------------------------------------------------------
* Switching on a 1 mF load: "a discharged capacitor is a short at t = 0".
*   CASE 0 : relay-like hard switch: gate slew removed (C_SLEW 1 pF,
*            RG_ON 10 Ohm) and every protection disabled -> the inrush is
*            limited only by the loop (~40 mOhm, 2 uH)
*   CASE 1 : the same hard switch with the protections active -> the eFuse
*            cannot tell the inrush from a short: HSC trip, OUT stuck low
*   CASE 2 : dV/dt-controlled turn-on (C_SLEW 68 nF) -> ~80 A, no fault
* Expected: CASE 0 several hundred A (loop L + R, VBAT sags), done in tens
* of us; CASE 1 HSC latch ~5-8 us after the current crosses IHSC;
* CASE 2 as tb11 (79 A, OUT at 95 % after ~0.7 ms).
* Interview guide: question D1.
* ---------------------------------------------------------------------------
.include ../models/VNF1048F_beh.lib
.param CASE=0
.param CSL={if(CASE==2, 68n, 1p)}
.param RGN={if(CASE==2, 2.2k, 10)}
.param HSCMV={if(CASE==0, 5000, 0)}
.param VOCMV={if(CASE==0, 5000, 0)}

Vbat bat 0 48
Rbat bat b1 10m
Lbat b1 vbat 1u
Dtvs 0 vbat EF_TVS58V
Cbus vbat 0 100u Rser=30m

X1 vbat out 0 en byp clr diag cs tfet EFUSE48_MOD RSENSE=1m OVC_CODE=13 HSC_CODE=12
+ VDS_CODE=14 TNOM_CODE=0 C_SLEW={CSL} RG_ON={RGN} HSC_MV={HSCMV} VOC_MV={VOCMV}

Lh out o1 1u
Rh o1 load 10m
Cload load 0 1m Rser=10m
Rbl load 0 4.7k
Dfw 0 out EF_SCH100V

Ven en 0 PWL(0 0 0.5m 0 0.501m 3.3)
Vbyp byp 0 0
Vclr clr 0 0

.save V(vbat) V(out) V(load) V(x1:drn) V(x1:g) I(Lh) V(tfet) V(x1:xu:hsht) V(x1:xu:flt)
.meas tran ipk    max I(Lh) from 0.5m to 3m
.meas tran t90    find time when V(load)=43.2 rise=1
.meas tran t_hsc  find time when V(x1:xu:hsht)=0.5 rise=1
.meas tran vbatmin min V(vbat) from 0.5m to 3m
.meas tran e_fet  integ V(x1:drn,out)*V(vbat,x1:drn)/1m from 0.5m to 3m
.meas tran vend   avg V(load) from 2.9m to 3m
.meas tran fltmax max V(x1:xu:flt)
.step param CASE list 0 1 2
.tran 0 3m 0 0.2u
.options plotwinsize=0
.end
