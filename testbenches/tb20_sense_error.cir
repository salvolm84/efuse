* tb20_sense_error.cir
* ---------------------------------------------------------------------------
* Current-sense error and the fuse curve.
* The controller settings stay fixed (OVC_CODE 13: VOC = 21.8 mV, ideal
* curve FUSE_MODE = 1, tNOM = 1 s) while the resistance the sense pins
* actually see is stepped: RSENSE = 0.9 / 1.0 / 1.1 / 1.2 mOhm
* (shunt tolerance, or 0.1..0.2 mOhm of copper inside a badly routed Kelvin
* path). Load: 10 A from 0.5 ms, overload step to ~40 A at 5 ms.
* Expected: the effective INOM is 21.8 mV/RSENSE = 24.2 / 21.8 / 19.8 /
* 18.2 A; the trip time t = (tNOM/32)/(x^2-1) at 40 A moves from
* ~18 ms (-10 %) to 13 ms (nominal), 10 ms (+10 %) and 8 ms (+20 %):
* a 10 % current error is a ~20 % error in I^2 and up to ~35 % in time.
* Interview guide: questions B4, E2.
* ---------------------------------------------------------------------------
.include ../models/VNF1048F_beh.lib
.param RS=1m

Vbat bat 0 48
Rbat bat b1 10m
Lbat b1 vbat 1u
Cbus vbat 0 100u Rser=30m

X1 vbat out 0 en byp clr diag cs tfet EFUSE48_MOD RSENSE={RS} OVC_CODE=13 HSC_CODE=12
+ VDS_CODE=14 TNOM_CODE=0 FUSE_MODE=1

Lh out o1 1u
Rh o1 load 10m
Cload load 0 47u Rser=20m
Rload load 0 4.8
Rov load ov 1.6
Sov ov 0 gov 0 SOV
Vgov gov 0 PWL(0 0 5m 0 5.001m 1)
.model SOV SW(Ron=2m Roff=1Meg Vt=0.5 Vh=-0.2)
Dfw 0 out SCH_100V

Ven en 0 PWL(0 0 0.5m 0 0.501m 3.3)
Vbyp byp 0 0
Vclr clr 0 0

.save V(out) V(cs) I(Lh) V(x1:xu:fd) V(x1:xu:fusel) V(x1:xu:xa)
.meas tran i10   avg I(Lh) from 3m to 4.5m
.meas tran cs10  avg V(cs) from 3m to 4.5m
.meas tran iov   avg I(Lh) from 6m to 7m
.meas tran xov   avg V(x1:xu:xa) from 6m to 7m
.meas tran t_fl  find time when V(x1:xu:fusel)=0.5 rise=1
.meas tran ttrip param t_fl-5m
.step param RS list 0.9m 1m 1.1m 1.2m
.tran 0 30m 0 5u
.options plotwinsize=0
.end
