* tb19_turnoff_speed.cir
* ---------------------------------------------------------------------------
* Gate turn-off path during a hard short: fast path vs slow turn-off.
* tb02 circuit (short at 3 ms) with the turn-off resistor of the module's
* fast path (RG_OFF in series with the diode around RG_ON) stepped:
*   RG_OFF = 10 Ohm (default) / 100 Ohm / 1 kOhm / 1 MOhm (= no fast path:
*   the gate discharges only through RG_ON = 2.2 kOhm while C_SLEW = 47 nF
*   holds it up; the 15 V gate-source zener keeps VGS at ~15 V meanwhile)
* Expected: a slower turn-off lowers di/dt at opening but lets the current
* keep rising, so peak current and FET energy grow. Without the fast path
* the FET stays on for tens of us at ~1 kA: the dV/dt slew network must not
* slow down the protective turn-off.
* Interview guide: questions B3 (follow-up), B5.
* ---------------------------------------------------------------------------
.include ../models/VNF1048F_beh.lib
.param RGOFF=10

Vbat bat 0 48
Rbat bat b1 10m
Lbat b1 vbat 1u
Dtvs 0 vbat EF_TVS58V
Cbus vbat 0 100u Rser=30m

X1 vbat out 0 en byp clr diag cs tfet EFUSE48_MOD RSENSE=1m OVC_CODE=13 HSC_CODE=12
+ VDS_CODE=14 TNOM_CODE=0 RG_OFF={RGOFF}

Lh out o1 1u
Rh o1 load 10m
Cload load 0 220u Rser=20m
Rload load 0 4.8
Dfw 0 out EF_SCH100V
Ssc load 0 sc 0 SSHORT
Vsc sc 0 PWL(0 0 3m 0 3.0001m 1)
.model SSHORT SW(Ron=5m Roff=1Meg Vt=0.5 Vh=-0.2)

Ven en 0 PWL(0 0 0.5m 0 0.501m 3.3)
Vbyp byp 0 0
Vclr clr 0 0

.save V(vbat) V(out) V(x1:drn) V(x1:g) I(Lh) V(tfet) V(x1:xu:hsht)
.meas tran t_trip  find time when V(x1:xu:hsht)=0.5 rise=1
.meas tran t_off   find time when V(vbat,x1:drn)=10m fall=last
.meas tran dt_off  param t_off-t_trip
.meas tran ipk     max I(Lh) from 3m to 4m
.meas tran vbatpk  max V(vbat) from 3m to 4m
.meas tran vdspk   max V(x1:drn,out) from 3m to 4m
.meas tran e_fet   integ V(x1:drn,out)*V(vbat,x1:drn)/1m from 3m to 4m
.meas tran tjpk    max V(tfet) from 3m to 4m
.step param RGOFF list 10 100 1k 1Meg
.tran 0 4m 0 0.1u
.options plotwinsize=0
.end
