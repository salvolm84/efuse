* bat07_pdn_48v.cir
* ---------------------------------------------------------------------------
* System bench: the 48 V zonal PDU of tb10, now fed by the 48 V battery pack
* model (BATTERY_BMS, defaults, SOC 80 %) instead of an ideal source, plus a
* belt starter-generator (BSG) and a battery disconnect.
*   pack --main harness (2 uH, 5 mOhm)-- bus (220 uF + TVS) --+-- CH1 eFuse -> 1 kW DC/DC
*                                                            +-- CH2 eFuse -> motor (12 A)
*                                                            +-- BSG (generator, current source)
*   t =  1 ms CH1 on, t = 4 ms CH2 on (staggered inrush)
*   t = 15 ms short circuit at the end of the CH2 harness (5 mOhm)
*   t = 25 ms BSG starts generating: 60 A into the bus (charges the battery)
*   t = 35 ms the BMS opens the pack (EN low: e.g. a cell fault). The BSG
*             regulator reacts only after ~5 ms -> the excess current charges
*             the bus capacitance: 48 V "load dump", clamped by the TVS.
* Expected: CH2 trips in < 10 us (HSC) while the pack current stays far below
* its I_SC (selectivity: the eFuse, not the battery, clears the fault); the
* bus dip is set by the pack + harness impedance. After the disconnect the
* bus rises at (I_gen - I_load)/C_bus until the TVS clamps.
* ---------------------------------------------------------------------------
.include ../models/VNF1048F_beh.lib
.include ../models/BATTERY_beh.lib

* 48 V pack + main harness to the PDU
Xbat bat 0 soc enb fltb BATTERY_BMS VNOM=48 SOC0=0.8
Venb enb 0 PWL(0 3.3 35m 3.3 35.001m 0)
Lmain bat bus 2u Rser=5m
Dtvs 0 bus EF_TVS58V
Cbus bus 0 220u Rser=20m

* ---- channel 1: DC/DC converter (as tb10)
X1 bus o1 0 en1 0 0 diag1 cs1 tfet1 EFUSE48_MOD RSENSE=1m OVC_CODE=22 HSC_CODE=14
+ VDS_CODE=14 TNOM_CODE=2
Lh1 o1 d1 1u Rser=10m
Cdc d1 0 470u Rser=15m
Rbl d1 0 4.7k
Bdcdc d1 0 I=if(V(dcen)>0.5, 1000/max(V(d1),20), 0)
Bdcen dcen_i 0 V=if(V(d1)>30, 1, if(V(d1)<26, 0, V(dcen)))
Rdcen dcen_i dcen 1k
Cdcen dcen 0 1n

* ---- channel 2: motor (as tb10)
X2 bus o2 0 en2 0 clr2 diag2 cs2 tfet2 EFUSE48_MOD RSENSE=1m OVC_CODE=13 HSC_CODE=12
+ VDS_CODE=14 TNOM_CODE=0
Lh2 o2 m2 1.5u Rser=15m
Cm2 m2 0 100u Rser=20m
Lm2 m2 mm 200u
Rm2 mm 0 3.8
Dfw2 0 o2 EF_SCH100V
Dfw1 0 o1 EF_SCH100V
Ssc m2 0 scg 0 SSC
Vscg scg 0 PWL(0 0 15m 0 15.0001m 1)
.model SSC SW(Ron=5m Roff=1Meg Vt=0.5 Vh=-0.2)

* ---- BSG: 60 A from 25 ms (2 ms soft start); its voltage regulator cuts the
*      current above 52 V with a 5 ms lag (first-order filter on the error)
Bgreg greg_i 0 V=limit((52.5-V(bus))/0.5, 0, 1)
Rgreg greg_i greg 1k
Cgreg greg 0 5u
Bgen 0 bus I=60*limit((time-25m)/2m, 0, 1)*V(greg)

Ven1 en1 0 PWL(0 0 1m 0 1.001m 3.3)
Ven2 en2 0 PWL(0 0 4m 0 4.001m 3.3)
Vclr2 clr2 0 0

.save V(bus) V(bat) V(o1) V(d1) V(o2) V(m2) V(dcen) V(diag1) V(diag2) V(fltb) V(soc)
.save I(Lh1) I(Lh2) I(Lmain) I(xbat:Vsw) I(Dtvs) V(greg) V(x2:xu:hsht) V(x1:xu:flt)
.save V(xbat:x) V(xbat:xc:ocv)
.meas tran t_trip2 find time when V(x2:xu:hsht)=0.5 rise=1
.meas tran dt_trip2 param t_trip2-15m
.meas tran ibat_pk max I(xbat:Vsw) from 15m to 15.1m
.meas tran ipk2 max I(Lh2) from 15m to 15.1m
.meas tran vbus_min min V(bus) from 15m to 15.2m
.meas tran vdc_min min V(d1) from 15m to 16m
.meas tran ch1_flt max V(x1:xu:flt)
.meas tran dcen_min min V(dcen) from 10m to 50m
.meas tran fltb_max max V(fltb) from 0 to 34m
.meas tran ibat_load avg I(xbat:Vsw) from 10m to 14m
.meas tran vbus_load avg V(bus) from 10m to 14m
.meas tran ibat_chg avg I(xbat:Vsw) from 31m to 34m
.meas tran vbus_chg avg V(bus) from 31m to 34m
.meas tran vbus_ld max V(bus) from 35m to 50m
.meas tran itvs_pk max -I(Dtvs) from 35m to 50m
.meas tran t_58 find time when V(bus)=58 rise=1 td=35m
.meas tran dt_58 param t_58-35m
.meas tran vbus_end find V(bus) at 50m
.tran 0 50m 0 0.5u
.options plotwinsize=0
.end
