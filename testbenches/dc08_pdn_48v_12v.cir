* dc08_pdn_48v_12v.cir
* ---------------------------------------------------------------------------
* Two-voltage system: 48 V pack (BATTERY_BMS) -> main harness -> 48 V bus ->
* eFuse CH1 (EFUSE48_MOD) -> 700 W 48/12 V DC/DC (DCDC48_12) -> 12 V harness
* -> 12 V net (BATTERY 70 Ah, SOC 70 %, plus 12 V loads). A second eFuse
* channel CH2 feeds a 48 V motor (as tb10).
*   t =  1 ms  CH1 on: the eFuse charges the DC/DC input capacitance (470 uF);
*              the DC/DC starts at its 30 V UVLO and soft-starts onto the
*              pre-biased 12 V net, then charges the 12 V battery at its
*              55 A current limit
*   t =  2 ms  CH2 (motor) on
*   t = 20 ms  12 V load step: +40 A (PTC heater) on a 10 A base load
*   t = 30 ms  short circuit at the end of the CH2 harness (48 V side)
* Expected: no eFuse trip on CH1 (DC/DC input ~16 A < INOM 39 A); the 12 V
* battery takes the 12 V load step (DC/DC already in current limit); the
* 48 V branch short is cleared by CH2 in < 10 us and the DC/DC rides through
* the 48 V dip (well above its 26 V UVLO): the 12 V net does not notice it.
* ---------------------------------------------------------------------------
.include ../models/VNF1048F_beh.lib
.include ../models/BATTERY_beh.lib
.include ../models/DCDC48_12_beh.lib

* ---- 48 V pack, main harness, bus
Vh hi 0 3.3
Xbat bat 0 soc48 hi fltb BATTERY_BMS VNOM=48 SOC0=0.8
Lmain bat bus 2u Rser=5m
Dtvs 0 bus EF_TVS58V
Cbus bus 0 220u Rser=20m

* ---- CH1: DC/DC (its 470 uF input capacitance is inside DCDC48_12)
X1 bus o1 0 en1 0 0 diag1 cs1 tfet1 EFUSE48_MOD RSENSE=1m OVC_CODE=22 HSC_CODE=14
+ VDS_CODE=14 TNOM_CODE=2
Lh1 o1 d1 1u Rser=10m
Dfw1 0 o1 EF_SCH100V
Xdc d1 v12 0 hi pgdc DCDC48_12
* input bleeder: the eFuse's 1.3 mA OUT bias current is larger than the
* DC/DC's 1 mA stand-by current and would otherwise charge its input with
* the channel off (tb10, README section 1.12)
Rbl d1 0 4.7k

* ---- CH2: motor (as tb10)
X2 bus o2 0 en2 0 0 diag2 cs2 tfet2 EFUSE48_MOD RSENSE=1m OVC_CODE=13 HSC_CODE=12
+ VDS_CODE=14 TNOM_CODE=0
Lh2 o2 m2 1.5u Rser=15m
Cm2 m2 0 100u Rser=20m
Lm2 m2 mm 200u
Rm2 mm 0 3.8
Dfw2 0 o2 EF_SCH100V
Vscg scg 0 PWL(0 0 30m 0 30.001m 1)
Bsc m2 0 I=V(m2)*(1u + V(scg)/5m)

* ---- 12 V net: harness to the battery, loads
Lh12 v12 b12 0.5u Rser=2m
Xb12 b12 0 soc12 BATTERY VNOM=12 SOC0=0.7
Rbase b12 0 1.25
Vph ph 0 PWL(0 0 20m 0 20.05m 1)
Bptc b12 0 I=40*V(ph)*limit(V(b12)/12, 0, 1.2)

Ven1 en1 0 PWL(0 0 1m 0 1.001m 3.3)
Ven2 en2 0 PWL(0 0 2m 0 2.001m 3.3)

.save V(bus) V(d1) V(v12) V(b12) V(pgdc) V(diag1) V(diag2) V(fltb) V(m2)
.save I(Lh1) I(Lh2) I(Lh12) I(xb12:Vi) I(xbat:Vsw) V(xdc:run) V(xdc:il) V(xdc:vref)
.save V(x1:xu:flt) V(x2:xu:hsht) V(xdc:uvok)
.meas tran t_dcrun find time when V(xdc:run)=0.5 rise=1
.meas tran vin_dcrun find V(d1) when V(xdc:run)=0.5 rise=1
.meas tran ich1_pk max I(Lh1) from 1m to 4m
.meas tran ich1_ss avg I(Lh1) from 15m to 19m
.meas tran ildc_ss avg V(xdc:il) from 15m to 19m
.meas tran ibat12_ss avg I(xb12:Vi) from 15m to 19m
.meas tran v12_ss avg V(b12) from 15m to 19m
.meas tran ibat12_ph avg I(xb12:Vi) from 26m to 29m
.meas tran v12_ph avg V(b12) from 26m to 29m
.meas tran ildc_ph avg V(xdc:il) from 26m to 29m
.meas tran t_trip2 find time when V(x2:xu:hsht)=0.5 rise=1
.meas tran dt_trip2 param t_trip2-30m
.meas tran vbus_min min V(bus) from 30m to 30.2m
.meas tran vdc_min min V(d1) from 30m to 31m
.meas tran uvdc_min min V(xdc:uvok) from 1.5m to 40m
.meas tran v12_min min V(b12) from 30m to 31m
.meas tran v12_pre avg V(b12) from 29m to 30m
.meas tran ch1_flt max V(x1:xu:flt)
.meas tran fltb_max max V(fltb)
.meas tran ibat48_ss avg I(xbat:Vsw) from 15m to 19m
.tran 0 40m 0 0.5u
.options plotwinsize=0
.end
